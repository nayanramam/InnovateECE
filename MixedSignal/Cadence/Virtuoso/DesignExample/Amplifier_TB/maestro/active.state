ADE simulation setup
Test DesignExample_Amplifier_TB_1: DesignExample/Amplifier_TB/schematic, simulator spectre
  Models: /nethome/pmathews30/AMS-Onboarding/PDK/sky130_release_0.0.9/libs/sky130_fd_pr_main/../../models/sky130.lib.spice[tt]
  Variables: Cl = 1p; Ibias = 10u; VDD_AC = 0; VDD_DC = 1.8; Vn_DC = 0.9; Vp_AC = 1; Vp_DC = 0.9
  Temperature: 27
  Analysis ac: start=1 stop=1G
  Output BW = bandwidth(VF("/Vout") 3 "low")
  Output Av = dB20(VF("/Vout"))
  Output Phase = phase(VF("/Vout"))
  Output PM = phaseMargin(VF("/Vout"))
  Signals: /Vp as V-, /Vn as Vn, /Vout as Vout
Test DC: DesignExample/Amplifier_TB/schematic, simulator spectre
  Models: /nethome/pmathews30/AMS-Onboarding/PDK/sky130_release_0.0.9/libs/sky130_fd_pr_main/../../models/sky130.lib.spice[tt]
  Variables: Cl = 100f; Ibias = 10u; VDD_AC = 0; VDD_DC = 1.8; Vp_AC = 0; Vp_DC = VDD_DC/2; Vn_DC = VDD_DC/2
  Temperature: 27
  Analysis dc: sweep Vp_DC start=0 stop=VDD_DC step=.01 (saves the operating point)
  Signals: /Vp as V+, /Vn as V-, /Vout as Vout
Test AC: DesignExample/Amplifier_TB/schematic, simulator spectre
  Models: /nethome/pmathews30/AMS-Onboarding/PDK/sky130_release_0.0.9/libs/sky130_fd_pr_main/../../models/sky130.lib.spice[tt]
  Variables: Cl = 1p; Ibias = 6u; VDD_AC = 0; VDD_DC = 1.8; Vn_DC = 0.9; Vp_AC = 1; Vp_DC = 0.9
  Temperature: 27
  Analysis ac: start=1 stop=1G
  Output BW = bandwidth(VF("/Vout") 3 "low")
  Output Av = dB20(VF("/Vout"))
  Output Phase = phase(VF("/Vout"))
  Output PM = phaseMargin(VF("/Vout"))
  Signals: /Vp as V-, /Vn as Vn, /Vout as Vout
