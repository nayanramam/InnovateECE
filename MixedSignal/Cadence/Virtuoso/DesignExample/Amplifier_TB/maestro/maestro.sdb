ADE simulation setup
Run mode: Single Run, Sweeps and Corners
Tests:
  DC: DesignExample/Amplifier_TB/schematic, simulator spectre
    Variables: Cl = 100f; Ibias = 10u; VDD_AC = 0; VDD_DC = 1.8; Vn_DC = VDD_DC/2; Vp_AC = 0; Vp_DC = VDD_DC/2
  AC: DesignExample/Amplifier_TB/schematic, simulator spectre
    Variables: Cl = 1p; Ibias = 6u; VDD_AC = 0; VDD_DC = 1.8; Vn_DC = 0.9; Vp_AC = 1; Vp_DC = 0.9
