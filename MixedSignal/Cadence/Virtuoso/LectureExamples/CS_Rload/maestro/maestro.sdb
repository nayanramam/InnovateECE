ADE simulation setup
Run mode: Single Run, Sweeps and Corners
Tests:
  LectureExamples_SPICE_Demo_1: LectureExamples/CS_Rload/schematic, simulator spectre
    Variables: VDD_DC = 1.8; VIN_DC = 0.65; VIN_SIN = 100m; F_SIN = 100e3; TSIM = 10*(1/F_SIN)
