ADE simulation setup
Test LectureExamples_SPICE_Demo_1: LectureExamples/CS_Rload/schematic, simulator spectre
  Models: /nethome/pmathews30/AMS-Onboarding/PDK/sky130_release_0.0.9/libs/sky130_fd_pr_main/../../models/sky130.lib.spice[tt]
  Variables: F_SIN = 100e3; VDD_DC = 1.8; VIN_DC = 0.65; VIN_SIN = 100m; TSIM = 10*(1/F_SIN)
  Temperature: 27
  Analysis tran: stop=VAR("TSIM")
  Signals: /Vout, /Vin
Run mode: Single Run, Sweeps and Corners
