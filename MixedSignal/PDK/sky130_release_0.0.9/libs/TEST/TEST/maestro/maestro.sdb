ADE simulation setup
Run mode: Single Run, Sweeps and Corners
Tests:
  TEST_TEST_1: TEST/TEST/schematic, simulator spectre
