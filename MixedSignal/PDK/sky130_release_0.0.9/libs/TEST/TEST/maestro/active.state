ADE simulation setup
Test TEST_TEST_1: TEST/TEST/schematic, simulator spectre
  Models: /home/icsrl7/tseol3_sky130nm/PDK/sky130_release_0.0.9/libs/sky130_fd_pr_main/../../models/sky130.lib.spice[tt]
  Temperature: 27
  Analysis tran: stop=1m
Run mode: Single Run, Sweeps and Corners
